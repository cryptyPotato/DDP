`include "constants.vams"
`include "disciplines.vams"

module nmos(D,G,S);
inout D,G,S;
electrical D,G,S;

parameter real Vth = 1.2;
parameter real alpha = 3.4;
parameter real gain  = 3.15e-6;
parameter real m = 3;
parameter real VT = 0.026;
parameter real k = 4;

real Vgs, Vds, Io, Iss, Ips, Ist;

analog begin
Vgs = V(G,GND) - V(S,GND);
Vds = V(D,GND) - V(S,GND);
//Vgo = 2*m*VT + Vth;
//Vgp = 2*k*VT + Vth;
Io = gain*(2*m*m*VT*VT)/alpha;
Iss = Io*exp((Vgs-Vth)/(m*VT));
Ips = Io*exp(2*k/m);
Ist = Iss*Ips/(Iss+Ips);
I(D,S) <+ Ist;

end
endmodule
