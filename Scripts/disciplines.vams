/*
  Copyright C 2007 Accellera Organization, Inc.
  Standard definitions
  This file contains the standard definition package disciplines.vams for Verilog-AMS HDL.
*/

`ifdef DISCIPLINES_VAMS
`else
`define DISCIPLINES_VAMS 1
//
// Natures and Disciplines
//
discipline logic
  domain discrete;
enddiscipline
/*
* Default absolute tolerances may be overridden by setting the
* appropriate _ABSTOL prior to including this file
*/
// Electrical
// Current in amperes
nature Current
  units = "A";
  access = I;
  idt_nature = Charge;
`ifdef CURRENT_ABSTOL
  abstol = `CURRENT_ABSTOL;
`else
  abstol = 1e-12;
`endif
endnature
// Charge in coulombs
nature Charge
  units = "coul";
  access = Q;
  ddt_nature = Current;
`ifdef CHARGE_ABSTOL
  abstol = `CHARGE_ABSTOL;
`else
  abstol = 1e-14;
`endif
endnature
// Potential in volts
nature Voltage
  units = "V";
  access = V;
  idt_nature = Flux;
`ifdef VOLTAGE_ABSTOL
  abstol = `VOLTAGE_ABSTOL;
`else
  abstol = 1e-6;
`endif
endnature
// Flux in Webers
nature Flux
  units = "Wb";
  access = Phi;
  ddt_nature = Voltage;
`ifdef FLUX_ABSTOL
  abstol = `FLUX_ABSTOL;
`else
  abstol = 1e-9;
`endif
endnature
// Conductance in Siemens
nature Conductance
  units = "S";
  access = G;
endnature
// Resistance in Ohms
nature Resistance
  units = "ohms";
  access = R;
endnature
// Capacitance in Farads
nature Capacitance
  units = "F";
  access = C;
endnature
// Conservative discipline
discipline electrical
  potential Voltage;
  flow Current;
  flow Conductance;
  flow Resistance;
  flow Capacitance;
enddiscipline
// Signal flow disciplines
discipline voltage
  potential Voltage;
enddiscipline
discipline current
  potential Current;
enddiscipline
// Thermal
// Temperature in Kelvin
nature Temperature
  units = "K";
  access = Temp;
`ifdef TEMPERATURE_ABSTOL
  abstol = `TEMPERATURE_ABSTOL;
`else
  abstol = 1e-4;
`endif
endnature
// Power in Watts
nature Power
  units = "W";
  access = Pwr;
`ifdef POWER_ABSTOL
  abstol = `POWER_ABSTOL;
`else
  abstol = 1e-9;
`endif
endnature
// Conservative discipline
discipline thermal
  potential Temperature;
  flow Power;
enddiscipline
`endif
